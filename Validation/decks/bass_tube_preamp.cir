* Bass Tube Preamp — exported from Lutherie
* A valve preamp voiced for bass: fully bypassed cathodes and large coupling capacitors keep the bottom octave, and the tone stack's capacitors are several times larger than a guitar amp's so Bass and Middle work an octave or two lower. It stays clean until Volume is well up, then growls.

Vsig SIGSRC 0 SIN(0 0.3 220.0) AC 1
Rsig SIGSRC IN 1k
RR1 IN 0 1Meg
RR2 IN N2 68k
XV1 N3 N2 N4 TRIODE_12AX7
RR3 N4 0 1.5k
CC1 N4 0 47u
RR4 VCC_320V N3 100k
CC2 N3 N6 47n
VVS4 VCC_320V 0 DC 320.0
* Volume pot 1Meg A taper at 55%
RVR1a 0 N7 128k
RVR1b N7 N6 872k
RR5 N7 N8 100k
XV2 N9 N8 N10 TRIODE_12AX7
RR6 N10 0 1.5k
RR7 VCC_320V N9 100k
XV3 VCC_320V N9 N11 TRIODE_12AX7
RR8 N11 0 100k
CC3 N11 N12 470p
* Treble pot 250k A taper at 60%
RVR2a N13 N14 40.5k
RVR2b N14 N12 209k
RR9 N11 N15 56k
CC4 N15 N13 100n
CC5 N15 N16 47n
* Bass pot 1Meg A taper at 50%
RVR3a N13 N16 100k
RVR3b N16 N16 900k
* Middle pot 25k B taper at 50%
RVR4a N16 0 12.5k
RVR4b 0 0 12.5k
* Master pot 1Meg A taper at 50%
RVR5a 0 OUT 100k
RVR5b OUT N14 900k
Rload OUT 0 1Meg

* Koren triode model
.subckt TRIODE_12AX7 P G K
Bp P K I=V(E1)>0 ? 2*pwr(V(E1),1.4)/1060.0 : 0
Be E1 0 V=V(P,K)/600.0*ln(1+exp(600.0*(1/100.0+V(G,K)/sqrt(300.0+V(P,K)*V(P,K)))))
Bg G K I=V(G,K)>0 ? pwr(V(G,K),1.5)/1300 : 0
Cgp G P 1.7e-12
Cgk G K 1.6e-12
Cpk P K 4.6e-13
.ends

.options reltol=1e-5 abstol=1e-13 vntol=1e-8 method=trap
.tran 1.3020833333333333e-06 0.3 0 1.3020833333333333e-06
.control
set wr_singlescale
set numdgt=12
run
wrdata bass_tube_preamp.ngspice.txt v(OUT)
.endc
.end
