* Diode Overdrive — exported from Lutherie
* Non-inverting op-amp stage with silicon diodes in the feedback loop (soft clipping), a treble-cut tone control and an output level.

Vsig SIGSRC 0 SIN(0 0.3 220.0) AC 1
Rsig SIGSRC IN 1k
CC1 IN N2 47n
RR1 N2 VCC_4p5V 1Meg
VVREF1 VCC_4p5V 0 DC 4.5
XU1 N2 N4 N5 OPAMP_JRC4558_14_76
DD1 N4 N5 D_1N4148
DD2 N5 N4 D_1N4148
CC2 N4 N5 51p
RR2 N4 N6 51k
* Drive pot 500k A taper at 50%
RVR1a N6 N5 50k
RVR1b N5 N5 450k
RR3 N7 N4 4.7k
CC3 VCC_4p5V N7 47n
RR4 N5 N8 1k
CC4 N8 N9 220n
* Tone pot 20k B taper at 50%
RVR2a N9 VCC_4p5V 10k
RVR2b VCC_4p5V VCC_4p5V 10k
CC5 N8 N10 1u
* Level pot 100k A taper at 80%
RVR3a 0 OUT 40.8k
RVR3b OUT N10 59.2k
Rload OUT 0 1Meg

.model D_1N4148 D(Is=2.52e-09 N=1.752 Rs=0.568 Cjo=4e-12 M=0)
* Behavioural op-amp: gain, gain-bandwidth, slew rate and output swing
.subckt OPAMP_JRC4558_14_76 INP INN OUT
Bin 0 M I=0.005305164769729844*tanh(0.1*V(INP,INN)/0.005305164769729844)
R1 M 0 1Meg
C1 M 0 5.305164769729845e-09
Bout X 0 V=4.5+3.0999999999999996*V(M)/3.0999999999999996/pwr(1+pwr(V(M)/3.0999999999999996,4),0.25)
Rout X OUT 75.0
.ends

.options reltol=1e-5 abstol=1e-13 vntol=1e-8 method=trap
.tran 1.3020833333333333e-06 0.3 0 1.3020833333333333e-06
.control
set wr_singlescale
set numdgt=12
run
wrdata diode_overdrive.ngspice.txt v(OUT)
.endc
.end
