* Tweed-Style Preamp — exported from Lutherie
* The simplest classic valve amp: two 12AX7 stages with a volume control between them and a single tone knob that bleeds treble to ground. Warm, and it breaks up early and smoothly.

Vsig SIGSRC 0 SIN(0 0.3 220.0) AC 1
Rsig SIGSRC IN 1k
RR1 IN 0 1Meg
RR2 IN N2 68k
XV1 N3 N2 N4 TRIODE_12AX7
RR3 N4 0 1.5k
CC1 N4 0 22u
RR4 VCC_250V N3 100k
CC2 N3 N6 22n
VVS4 VCC_250V_src 0 DC 250.0
RVS4s VCC_250V_src VCC_250V 0.01
* Volume pot 1Meg A taper at 60%
RVR1a 0 N7 162k
RVR1b N7 N6 838k
XV2 N8 N7 N9 TRIODE_12AX7
RR5 N9 0 1.5k
CC3 N9 0 22u
RR6 VCC_250V N8 100k
CC4 N8 N10 22n
CC5 N10 N11 4.7n
* Tone pot 1Meg A taper at 60%
RVR2a N11 0 162k
RVR2b 0 0 838k
* Master pot 1Meg A taper at 50%
RVR3a 0 OUT 100k
RVR3b OUT N10 900k
Rload OUT 0 1Meg

* Koren triode model
.subckt TRIODE_12AX7 P G K
Bp P K I=V(E1)>0 ? 2*pwr(V(E1),1.4)/1060.0 : 0
Be E1 0 V=V(P,K)/600.0*ln(1+exp(600.0*(1/100.0+V(G,K)/sqrt(300.0+V(P,K)*V(P,K)))))
Bg G K I=V(G,K)>0 ? pwr(V(G,K),1.5)/1300 : 0
Cgp G P 1.7e-12
Cgk G K 1.6e-12
Cpk P K 4.6e-13
.ends

.options reltol=1e-5 abstol=1e-13 vntol=1e-8 method=trap
.tran 1.3020833333333333e-06 0.3 0 1.3020833333333333e-06
.control
set wr_singlescale
set numdgt=12
run
wrdata tweed_style_preamp.ngspice.txt v(OUT)
.endc
.end
